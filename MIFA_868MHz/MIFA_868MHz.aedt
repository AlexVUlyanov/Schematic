# Ansys Electronics Desktop project, version 2021.2
materials:
  vacuum: permittivity=1
  FR4_epoxy: permittivity=4.4 dielectric_loss_tangent=0.02
  pec: conductivity=1e+30
  PMLGroup1_Z_1: permittivity{anisotropic component1=1.439359 component2=1.439359 component3=0.34737686} permeability{anisotropic component1=1.439359 component2=1.439359 component3=0.34737686} dielectric_loss_tangent{anisotropic component1=1 component2=1 component3=-1} magnetic_loss_tangent{anisotropic component1=1 component2=1 component3=-1}
  PMLGroup1_XZ_1: permittivity{anisotropic component1=1 component2=0.01 component3=1} permeability{anisotropic component1=1 component2=0.01 component3=1} dielectric_loss_tangent{anisotropic component1=0 component2=414.35085 component3=0} magnetic_loss_tangent{anisotropic component1=0 component2=414.35085 component3=0}
  PMLGroup1_YZ_1: permittivity{anisotropic component1=0.01 component2=1 component3=1} permeability{anisotropic component1=0.01 component2=1 component3=1} dielectric_loss_tangent{anisotropic component1=414.35085 component2=0 component3=0} magnetic_loss_tangent{anisotropic component1=414.35085 component2=0 component3=0}
  PMLGroup1_XYZ_1: permittivity{anisotropic component1=1.439359 component2=1.439359 component3=1.439359} permeability{anisotropic component1=1.439359 component2=1.439359 component3=1.439359} dielectric_loss_tangent{anisotropic component1=1 component2=1 component3=1} magnetic_loss_tangent{anisotropic component1=1 component2=1 component3=1}
  Rogers RO4232 (tm): permittivity=3.2 dielectric_loss_tangent=0.0018

design HFSSDesign1 (HFSS, DrivenModal, model units mm)
variables:
  Y_ = 48mm
  X_ = 62mm
geometry:
  GND = rectangle(corner=(0, -Y_/2, 0mm), x_size=X_, y_size=Y_)
  Rectangle8 = rectangle(corner=(-0.2mm, -16mm, 0mm), x_size=0.2mm, y_size=2mm)
  L1 = imported_body()
  Box1 [Rogers RO4232 (tm)] = box(corner=(-22mm, (-49/2) mm, 0mm), size=(85mm, 49mm, -1mm))
  GND1 = rectangle(corner=(0, -Y_/2, -1mm), x_size=X_, y_size=Y_)
  RadiatingSurface [vacuum] = region(absolute_offset=86.40553mm on all sides)
  coordinate_system FaceCS1 = face of RadiatingSurface: Origin=RadiatingSurface.vertex(1 of 8) FaceID=RadiatingSurface.face(+z) AxisPosn=RadiatingSurface.vertex(2 of 8) WhichAxis=X ZRotationAngle=0deg XOffset=0mm YOffset=0mm
  PML_RadiatingSurface_1 [PMLGroup1_Z_1, oriented by FaceCS1] = sweep_along_normal(RadiatingSurface.face(+z), length=107.369mm)
  coordinate_system FaceCS2 = face of RadiatingSurface: Origin=RadiatingSurface.vertex(5 of 8) FaceID=RadiatingSurface.face(-z) AxisPosn=RadiatingSurface.vertex(6 of 8) WhichAxis=X ZRotationAngle=0deg XOffset=0mm YOffset=0mm
  PML_RadiatingSurface_2 [PMLGroup1_Z_1, oriented by FaceCS2] = sweep_along_normal(RadiatingSurface.face(-z), length=107.369mm)
  coordinate_system FaceCS3 = face of RadiatingSurface: Origin=RadiatingSurface.vertex(4 of 8) FaceID=RadiatingSurface.face(-y) AxisPosn=RadiatingSurface.vertex(7 of 8) WhichAxis=X ZRotationAngle=0deg XOffset=0mm YOffset=0mm
  PML_RadiatingSurface_3 [PMLGroup1_Z_1, oriented by FaceCS3] = sweep_along_normal(RadiatingSurface.face(-y), length=107.369mm)
  coordinate_system FaceCS4 = face of RadiatingSurface: Origin=RadiatingSurface.vertex(3 of 8) FaceID=RadiatingSurface.face(-x) AxisPosn=RadiatingSurface.vertex(8 of 8) WhichAxis=X ZRotationAngle=0deg XOffset=0mm YOffset=0mm
  PML_RadiatingSurface_4 [PMLGroup1_Z_1, oriented by FaceCS4] = sweep_along_normal(RadiatingSurface.face(-x), length=107.369mm)
  coordinate_system FaceCS5 = face of RadiatingSurface: Origin=RadiatingSurface.vertex(2 of 8) FaceID=RadiatingSurface.face(+y) AxisPosn=RadiatingSurface.vertex(5 of 8) WhichAxis=X ZRotationAngle=0deg XOffset=0mm YOffset=0mm
  PML_RadiatingSurface_5 [PMLGroup1_Z_1, oriented by FaceCS5] = sweep_along_normal(RadiatingSurface.face(+y), length=107.369mm)
  coordinate_system FaceCS6 = face of RadiatingSurface: Origin=RadiatingSurface.vertex(1 of 8) FaceID=RadiatingSurface.face(+x) AxisPosn=RadiatingSurface.vertex(6 of 8) WhichAxis=X ZRotationAngle=0deg XOffset=0mm YOffset=0mm
  PML_RadiatingSurface_6 [PMLGroup1_Z_1, oriented by FaceCS6] = sweep_along_normal(RadiatingSurface.face(+x), length=107.369mm)
  PML_RadiatingSurface_7 [PMLGroup1_XZ_1, oriented by FaceCS3] = sweep_along_normal(PML_RadiatingSurface_1.face(at (20.5, -110.906, 140.09)), length=107.369mm)
  PML_RadiatingSurface_8 [PMLGroup1_XZ_1, oriented by FaceCS4] = sweep_along_normal(PML_RadiatingSurface_1.face(at (-108.406, 0, 140.09)), length=107.369mm)
  PML_RadiatingSurface_9 [PMLGroup1_XZ_1, oriented by FaceCS5] = sweep_along_normal(PML_RadiatingSurface_1.face(at (20.5, 110.906, 140.09)), length=107.369mm)
  PML_RadiatingSurface_10 [PMLGroup1_YZ_1, oriented by FaceCS1] = sweep_along_normal(PML_RadiatingSurface_1.face(at (149.406, 0, 140.09)), length=107.369mm)
  coordinate_system FaceCS7 = face of RadiatingSurface: Origin=RadiatingSurface.vertex(6 of 8) FaceID=RadiatingSurface.face(-z) AxisPosn=RadiatingSurface.vertex(7 of 8) WhichAxis=X ZRotationAngle=0deg XOffset=0mm YOffset=0mm
  PML_RadiatingSurface_11 [PMLGroup1_YZ_1, oriented by FaceCS7] = sweep_along_normal(PML_RadiatingSurface_2.face(at (20.5, -110.906, -141.09)), length=107.369mm)
  coordinate_system FaceCS8 = face of RadiatingSurface: Origin=RadiatingSurface.vertex(7 of 8) FaceID=RadiatingSurface.face(-z) AxisPosn=RadiatingSurface.vertex(8 of 8) WhichAxis=X ZRotationAngle=0deg XOffset=0mm YOffset=0mm
  PML_RadiatingSurface_12 [PMLGroup1_YZ_1, oriented by FaceCS8] = sweep_along_normal(PML_RadiatingSurface_2.face(at (-108.406, 0, -141.09)), length=107.369mm)
  PML_RadiatingSurface_13 [PMLGroup1_XZ_1, oriented by FaceCS2] = sweep_along_normal(PML_RadiatingSurface_2.face(at (20.5, 110.906, -141.09)), length=107.369mm)
  PML_RadiatingSurface_14 [PMLGroup1_YZ_1, oriented by FaceCS2] = sweep_along_normal(PML_RadiatingSurface_2.face(at (149.406, 0, -141.09)), length=107.369mm)
  PML_RadiatingSurface_15 [PMLGroup1_YZ_1, oriented by FaceCS3] = sweep_along_normal(PML_RadiatingSurface_3.face(at (-108.406, -164.59, -0.5)), length=107.369mm)
  PML_RadiatingSurface_16 [PMLGroup1_YZ_1, oriented by FaceCS6] = sweep_along_normal(PML_RadiatingSurface_3.face(at (149.406, -164.59, -0.5)), length=107.369mm)
  PML_RadiatingSurface_17 [PMLGroup1_YZ_1, oriented by FaceCS4] = sweep_along_normal(PML_RadiatingSurface_4.face(at (-162.09, 110.906, -0.5)), length=107.369mm)
  PML_RadiatingSurface_18 [PMLGroup1_YZ_1, oriented by FaceCS5] = sweep_along_normal(PML_RadiatingSurface_5.face(at (149.406, 164.59, -0.5)), length=107.369mm)
  PML_RadiatingSurface_19 [PMLGroup1_XYZ_1, oriented by FaceCS3] = sweep_along_normal(PML_RadiatingSurface_7.face(at (-108.406, -164.59, 140.09)), length=107.369mm)
  PML_RadiatingSurface_20 [PMLGroup1_XYZ_1, oriented by FaceCS1] = sweep_along_normal(PML_RadiatingSurface_7.face(at (149.406, -164.59, 140.09)), length=107.369mm)
  PML_RadiatingSurface_21 [PMLGroup1_XYZ_1, oriented by FaceCS4] = sweep_along_normal(PML_RadiatingSurface_8.face(at (-162.09, 110.906, 140.09)), length=107.369mm)
  PML_RadiatingSurface_22 [PMLGroup1_XYZ_1, oriented by FaceCS5] = sweep_along_normal(PML_RadiatingSurface_9.face(at (149.406, 164.59, 140.09)), length=107.369mm)
  PML_RadiatingSurface_23 [PMLGroup1_XYZ_1, oriented by FaceCS8] = sweep_along_normal(PML_RadiatingSurface_11.face(at (-108.406, -164.59, -141.09)), length=107.369mm)
  PML_RadiatingSurface_24 [PMLGroup1_XYZ_1, oriented by FaceCS7] = sweep_along_normal(PML_RadiatingSurface_11.face(at (149.406, -164.59, -141.09)), length=107.369mm)
  coordinate_system FaceCS9 = face of RadiatingSurface: Origin=RadiatingSurface.vertex(8 of 8) FaceID=RadiatingSurface.face(-z) AxisPosn=RadiatingSurface.vertex(5 of 8) WhichAxis=X ZRotationAngle=0deg XOffset=0mm YOffset=0mm
  PML_RadiatingSurface_25 [PMLGroup1_XYZ_1, oriented by FaceCS9] = sweep_along_normal(PML_RadiatingSurface_12.face(at (-162.09, 110.906, -141.09)), length=107.369mm)
  PML_RadiatingSurface_26 [PMLGroup1_XYZ_1, oriented by FaceCS2] = sweep_along_normal(PML_RadiatingSurface_13.face(at (149.406, 164.59, -141.09)), length=107.369mm)
  L1.unite(GND)
  Rectangle10 = rectangle(corner=(-19mm, -18mm, 0mm), x_size=19mm, y_size=-1mm)
  Rectangle10.move(0mm, 1mm, 0mm)
  L1.unite(Rectangle10)
  Rectangle11 = rectangle(corner=(-20mm, 20mm, 0mm), x_size=18mm, y_size=1mm)
  L1.subtract(Rectangle11)
  Rectangle12 = rectangle(corner=(-20mm, 20mm, 0mm), x_size=1mm, y_size=-0.2mm)
  L1.subtract(Rectangle12)
boundaries and excitations:
  PerfE3: Perfect E Objects=GND1
  PML_radiation1: Radiation Faces=RadiatingSurface.face(+z) IsForPML
  PML_radiation2: Radiation Faces=RadiatingSurface.face(-z) IsForPML
  PML_radiation3: Radiation Faces=RadiatingSurface.face(-y) IsForPML
  PML_radiation4: Radiation Faces=RadiatingSurface.face(-x) IsForPML
  PML_radiation5: Radiation Faces=RadiatingSurface.face(+y) IsForPML
  PML_radiation6: Radiation Faces=RadiatingSurface.face(+x) IsForPML
  PerfE4: Perfect E Objects=L1
  1: Lumped Port Objects=Rectangle8 Modes{Mode1{IntLine{middle of Rectangle8.edge(x opposite corner) -> middle of Rectangle8.edge(x at corner)} CharImp=Zpi}} Impedance=50ohm
setups:
  Setup1: HfssDriven Frequency=868MHz MaxDeltaS=0.01 MaximumPasses=36 MinimumPasses=1 MinimumConvergedPasses=1 PercentRefinement=30 BasisOrder=1 PortAccuracy=2 UseABCOnPort
    sweep Sweep: 800MHz to 1GHz step 1MHz; Type=Interpolating InterpTolerance=0.5 InterpMaxSolns=250 InterpUsePortImped=false PassivityErrorTolerance=0.0001
source amplitudes:
  1:1: 1W 0deg
radiation setups:
  3D: Infinite Sphere Theta=0deg..180deg step 2deg Phi=-180deg..180deg step 2deg
  Elevation: Infinite Sphere Theta=-180deg..180deg step 1deg Phi=0deg..90deg step 90deg
  Azimuth: Infinite Sphere Theta=90deg..90deg step 0deg Phi=-180deg..180deg step 1deg
field plots:
  Mag_E1: E Field on Setup1 : LastAdaptive at Freq=868MHz Phase=90deg
  Mag_H1: H Field on Setup1 : LastAdaptive at Freq=868MHz Phase=90deg
reports:
  S Parameter Plot 1: dB(S(1,1)) vs Freq on Setup1 : Sweep; markers m1 at 0.868GHz, MX1 at x=8.68e+08
  VSWR Plot 1: VSWR(1) vs Freq on Setup1 : Sweep; markers m1 at 0.868GHz, MX1 at x=8.68e+08
  S Parameter Chart 1: S(1,1) on Setup1 : Sweep [Freq=all]; markers m1 at 0.868GHz
  Gain Plot: dB(GainTotal) vs Phi, Theta on Setup1 : LastAdaptive, 3D [Freq=0.868GHz]
