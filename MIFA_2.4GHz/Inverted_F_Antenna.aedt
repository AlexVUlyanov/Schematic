# Ansys Electronics Desktop project, version 2021.2
materials:
  air: permittivity=1.0006 permeability=1.0000004
  vacuum: permittivity=1
  pec: conductivity=1e+30
  copper: permittivity=1 permeability=0.999991 conductivity=58000000
  FR4_epoxy: permittivity=4.4 dielectric_loss_tangent=0.02
  Rogers RO4003 (tm): permittivity=3.55 dielectric_loss_tangent=0.0027

design HFSSDesign1 (HFSS, DrivenTerminal, model units mm)
options: Allow_Material_Override Calculate_Lossy_Dielectrics Save_Adaptive_support_files
geometry:
  Antenna [copper] = imported_body()
  Antenna.move(-60.298203mm, -180.222398mm, 0mm)
  Antenna.rotate(axis=Z, angle=90deg)
  GND_top = rectangle(corner=(1mm, -11mm, 0mm), x_size=20mm, y_size=35mm)
  Rectangle3 = rectangle(corner=(1.139698mm, 2.0894236mm, 0mm), x_size=0.160302mm, y_size=0.41057641mm)
  Antenna.subtract(Rectangle3)
  PCB [FR4_epoxy] = box(corner=(-8mm, -12mm, 0mm), size=(30mm, 37mm, -1mm))
  GND_bottom = rectangle(corner=(1mm, -11mm, -1mm), x_size=20mm, y_size=35mm)
  Rectangle4 = rectangle(corner=(0.898398mm, -1.751203mm, 0mm), x_size=0.101602mm, y_size=0.131203mm)
  Antenna.unite(Rectangle4)
  RadiatingSurface [vacuum] = region(absolute_offset=15.625mm on all sides)
  Rectangle5 = rectangle(corner=(1mm, 0.6mm, 0mm), x_size=0.2mm, y_size=0.6mm)
  GND_top.subtract(Rectangle5)
  Rectangle9 = rectangle(corner=(1mm, 0.6mm, 0mm), x_size=0.2mm, y_size=1mm)
  GND_top.unite(Rectangle9)
  Rectangle13 = rectangle(corner=(0.68mm, 2.06mm, 0mm), x_size=4.27mm, y_size=0.456mm)
  Antenna.unite(Rectangle13)
  Rectangle15 = rectangle(corner=(4.95mm, 2.06mm, 0mm), x_size=0.05mm, y_size=0.456mm)
  Rectangle19 = rectangle(corner=(1mm, 1.65mm, 0mm), x_size=4mm, y_size=-0.65mm)
  GND_top.subtract(Rectangle19)
  Rectangle20 = rectangle(corner=(1mm, 1.65mm, 0mm), x_size=4mm, y_size=25mm)
  GND_top.subtract(Rectangle20)
  Rectangle21 = rectangle(corner=(-6.4mm, 17.2mm, 0mm), x_size=1.6mm, y_size=-0.95mm)
  Antenna.subtract(Rectangle21)
boundaries and excitations:
  PerfE1: Perfect E Objects=Antenna
  PerfE2: Perfect E Objects=GND_top
  PerfE3: Perfect E Objects=GND_bottom
  Open1: FE-BI Objects=RadiatingSurface UseAdaptiveIE
  Antenna_T1: Terminal port=1 Edges=Antenna.edge(2 of 4) TerminalResistance=50ohm
  1: Lumped Port Faces=Rectangle15.face Impedance=50ohm
  reference conductors: GND_top
mesh:
  initial mesh: MeshMethod=AnsoftClassic
setups:
  Setup1: HfssDriven Frequency=2.4GHz MaxDeltaS=0.01 MaximumPasses=36 MinimumPasses=1 MinimumConvergedPasses=1 PercentRefinement=30 BasisOrder=-1 Target=0.666667 PortAccuracy=2 UseDomains DDMSolverResidual=0.0001 SaveAnyFields=false
    sweep Sweep1: 2GHz to 3GHz, 500 points; Type=Interpolating InterpTolerance=0.5 InterpMaxSolns=250 InterpUsePortImped=false InterpUsePropConst=false PassivityErrorTolerance=0.0001
source amplitudes:
  1:1: 1V 0deg
radiation setups:
  3D: Infinite Sphere Theta=0deg..180deg step 2deg Phi=-180deg..180deg step 2deg
  Elevation: Infinite Sphere Theta=-180deg..180deg step 1deg Phi=0deg..90deg step 90deg
  Azimuth: Infinite Sphere Theta=90deg..90deg step 0deg Phi=-180deg..180deg step 1deg
reports:
  Terminal S Parameter Plot 1: dB(St(Antenna_T1,Antenna_T1)) vs Freq on Setup1 : Sweep1; markers MX1 at x=2.4e+09
  Terminal Z Parameter Plot 1: im(Zt(Antenna_T1,Antenna_T1)), re(Zt(Antenna_T1,Antenna_T1)) vs Freq on Setup1 : Sweep1; markers MX1 at x=2.4e+09
  Terminal VSWR Plot 1: VSWRt(Antenna_T1) vs Freq on Setup1 : Sweep1; markers MX1 at x=2.4e+09
